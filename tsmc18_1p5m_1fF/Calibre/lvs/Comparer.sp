* SPICE NETLIST
***************************************

.SUBCKT crtmom PLUS MINUS BULK
.ENDS
***************************************
.SUBCKT crtmom_rf PLUS MINUS BULK
.ENDS
***************************************
.SUBCKT cfmom PLUS MINUS BULK
.ENDS
***************************************
.SUBCKT cfmom_rf PLUS MINUS BULK
.ENDS
***************************************
.SUBCKT cfmom_mx PLUS1 MINUS1 PLUS2 MINUS2 BULK
.ENDS
***************************************
.SUBCKT efuse PLUS MINUS
.ENDS
***************************************
.SUBCKT hvpwdnwhvnw_dio_hvpw_3t PLUS MINUS SUB
.ENDS
***************************************
.SUBCKT lcesd1_rf PLUS MINUS
.ENDS
***************************************
.SUBCKT lcesd2_rf PLUS MINUS
.ENDS
***************************************
.SUBCKT lowcpad_rf APAD AVSS
.ENDS
***************************************
.SUBCKT lvpwdnwhvnw_dio_hvpw_3t PLUS MINUS SUB
.ENDS
***************************************
.SUBCKT mimcap_1p0_sin TOP BOT
.ENDS
***************************************
.SUBCKT mimcap_1p0_sin_3t PLUS MINUS BULK
.ENDS
***************************************
.SUBCKT mimcap_1p0_sin_hl TOP BOT
.ENDS
***************************************
.SUBCKT mimcap_1p0_sin_hl_3t PLUS MINUS BULK
.ENDS
***************************************
.SUBCKT mimcap_1p5_sin TOP BOT
.ENDS
***************************************
.SUBCKT mimcap_1p5_sin_3t PLUS MINUS BULK
.ENDS
***************************************
.SUBCKT mimcap_2p0_shield PLUS MINUS BULK
.ENDS
***************************************
.SUBCKT mimcap_2p0_sin TOP BOT
.ENDS
***************************************
.SUBCKT mimcap_2p0_sin_3t PLUS MINUS BULK
.ENDS
***************************************
.SUBCKT mimcap_2p0_wos PLUS MINUS BULK
.ENDS
***************************************
.SUBCKT mimcap_shield PLUS MINUS BULK
.ENDS
***************************************
.SUBCKT mimcap_wos PLUS MINUS BULK
.ENDS
***************************************
.SUBCKT moscap_rf33 PLUS MINUS BULK
.ENDS
***************************************
.SUBCKT moscap_rf33_nw PLUS MINUS BULK
.ENDS
***************************************
.SUBCKT moscap_rf PLUS MINUS BULK
.ENDS
***************************************
.SUBCKT moscap_rf_nw PLUS MINUS BULK
.ENDS
***************************************
.SUBCKT nch_hv5_5vnw_ac D G S B
.ENDS
***************************************
.SUBCKT LDDN D G S B
.ENDS
***************************************
.SUBCKT nch_hva_mac D G S B
.ENDS
***************************************
.SUBCKT nch_hva_ndd_mac D G S B
.ENDS
***************************************
.SUBCKT nch_hvau_ndd_mac D G S B
.ENDS
***************************************
.SUBCKT nch_hvi_mac D G BS SUB
.ENDS
***************************************
.SUBCKT nch_hviah_ndd_mac D G S B
.ENDS
***************************************
.SUBCKT nch_hvish_nbl_mac D G S B NBL_ISO SUB
.ENDS
***************************************
.SUBCKT nch_hvish_ndd_mac D G S B
.ENDS
***************************************
.SUBCKT nch_hvisl_mac D G S B
.ENDS
***************************************
.SUBCKT nch_hvnw_6t D G S B HVNW_ISO SUB
.ENDS
***************************************
.SUBCKT nch_hvs_mac D G S B
.ENDS
***************************************
.SUBCKT nch_hvs_ndd_mac D G S B
.ENDS
***************************************
.SUBCKT nch_hvsl_mac D G S B
.ENDS
***************************************
.SUBCKT nch_hvsu_ndd_mac D G S B
.ENDS
***************************************
.SUBCKT ndio_hia_rf PLUS MINUS
.ENDS
***************************************
.SUBCKT ndio_sbd_mac PLUS MINUS
.ENDS
***************************************
.SUBCKT ndld24_g5_ac D G BS SUB
.ENDS
***************************************
.SUBCKT ndld40_g5_ac D G BS SUB
.ENDS
***************************************
.SUBCKT nhvpwdnw10_4t C B E SUB
.ENDS
***************************************
.SUBCKT nhvpwdnw5_4t C B E SUB
.ENDS
***************************************
.SUBCKT nld12_g12_mac D G BS SUB
.ENDS
***************************************
.SUBCKT nld12_g2_mac D G BS SUB
.ENDS
***************************************
.SUBCKT nld14_g12_mac D G BS SUB
.ENDS
***************************************
.SUBCKT nld14_g2_mac D G BS SUB
.ENDS
***************************************
.SUBCKT nld18_g5_ac D G BS SUB
.ENDS
***************************************
.SUBCKT nld24_g5_ac D G BS SUB
.ENDS
***************************************
.SUBCKT nld32_g5_ac D G BS SUB
.ENDS
***************************************
.SUBCKT nld40_g5_ac D G BS SUB
.ENDS
***************************************
.SUBCKT nld60_g5_ac D G BS SUB
.ENDS
***************************************
.SUBCKT nmos_rf D G S B
.ENDS
***************************************
.SUBCKT nmos_rf33 D G S B
.ENDS
***************************************
.SUBCKT nmos_rf33_6t D G S B NG PG
.ENDS
***************************************
.SUBCKT nmos_rf_6t D G S B NG PG
.ENDS
***************************************
.SUBCKT nmoscap PLUS MINUS
.ENDS
***************************************
.SUBCKT nmoscap_33 PLUS MINUS
.ENDS
***************************************
.SUBCKT nmoscap_33_mis PLUS MINUS
.ENDS
***************************************
.SUBCKT nmoscap_mis PLUS MINUS
.ENDS
***************************************
.SUBCKT nvmrpodrpo_m PLUS MINUS B
.ENDS
***************************************
.SUBCKT LDDP D G S B
.ENDS
***************************************
.SUBCKT pa18_g5_ac D G S B SUB
.ENDS
***************************************
.SUBCKT pa24_g5_ac D G S B SUB
.ENDS
***************************************
.SUBCKT pa32_g5_ac D G S B SUB
.ENDS
***************************************
.SUBCKT pa40_g5_full_soa_ac D G S B SUB
.ENDS
***************************************
.SUBCKT pa40_g5_low_ron_ac D G S B SUB
.ENDS
***************************************
.SUBCKT pa50_g5_ac D G S B SUB
.ENDS
***************************************
.SUBCKT pa60_g5_full_soa_ac D G S B SUB
.ENDS
***************************************
.SUBCKT pch_5t D G S B SUB
.ENDS
***************************************
.SUBCKT pch_hva_mac D G S B SUB
.ENDS
***************************************
.SUBCKT pch_hva_pdd_mac D G S B
.ENDS
***************************************
.SUBCKT pch_hvau_pdd_mac D G S B
.ENDS
***************************************
.SUBCKT pch_hvs_mac D G S B SUB
.ENDS
***************************************
.SUBCKT pch_hvs_pdd_mac D G S B
.ENDS
***************************************
.SUBCKT pch_hvsl_mac D G S B
.ENDS
***************************************
.SUBCKT pch_hvsu_pdd_mac D G S B
.ENDS
***************************************
.SUBCKT pdio_hia_rf PLUS MINUS BULK
.ENDS
***************************************
.SUBCKT phvnw_dio_hvpw_3t PLUS MINUS SUB
.ENDS
***************************************
.SUBCKT pmos_rf D G S B
.ENDS
***************************************
.SUBCKT pmos_rf33 D G S B
.ENDS
***************************************
.SUBCKT pmos_rf33_5t D G S B PG
.ENDS
***************************************
.SUBCKT pmos_rf33_nw D G S B
.ENDS
***************************************
.SUBCKT pmos_rf33_nw_5t D G S B PG
.ENDS
***************************************
.SUBCKT pmos_rf_5t D G S B PG
.ENDS
***************************************
.SUBCKT pmos_rf_nw D G S B
.ENDS
***************************************
.SUBCKT pmos_rf_nw_5t D G S B PG
.ENDS
***************************************
.SUBCKT rhim PLUS MINUS
.ENDS
***************************************
.SUBCKT rhvnw PLUS MINUS BULK
.ENDS
***************************************
.SUBCKT rhvnw_60 PLUS MINUS BULK
.ENDS
***************************************
.SUBCKT rhvnwhvpw PLUS MINUS BULK
.ENDS
***************************************
.SUBCKT rhvpw PLUS MINUS BULK
.ENDS
***************************************
.SUBCKT rhvpw_60 PLUS MINUS BULK
.ENDS
***************************************
.SUBCKT rldpwod PLUS MINUS BULK
.ENDS
***************************************
.SUBCKT rldpwsti PLUS MINUS BULK
.ENDS
***************************************
.SUBCKT rnddhvpw PLUS MINUS BULK
.ENDS
***************************************
.SUBCKT rnod_m PLUS MINUS B
.ENDS
***************************************
.SUBCKT rnodrpo_m PLUS MINUS B
.ENDS
***************************************
.SUBCKT rnodw_m PLUS MINUS B
.ENDS
***************************************
.SUBCKT rnpo1_dis PLUS MINUS B
.ENDS
***************************************
.SUBCKT rnpo1rpo_dis PLUS MINUS B
.ENDS
***************************************
.SUBCKT rnpo1w_dis PLUS MINUS B
.ENDS
***************************************
.SUBCKT rnwod_ell PLUS MINUS
.ENDS
***************************************
.SUBCKT rnwod_ell_m PLUS MINUS B
.ENDS
***************************************
.SUBCKT rnwod_m PLUS MINUS B
.ENDS
***************************************
.SUBCKT rnwod_ull PLUS MINUS
.ENDS
***************************************
.SUBCKT rnwod_ull_m PLUS MINUS B
.ENDS
***************************************
.SUBCKT rnwsti_ell PLUS MINUS
.ENDS
***************************************
.SUBCKT rnwsti_ell_m PLUS MINUS B
.ENDS
***************************************
.SUBCKT rnwsti_m PLUS MINUS B
.ENDS
***************************************
.SUBCKT rnwsti_ull PLUS MINUS
.ENDS
***************************************
.SUBCKT rnwsti_ull_m PLUS MINUS B
.ENDS
***************************************
.SUBCKT rpbody PLUS MINUS BULK
.ENDS
***************************************
.SUBCKT rpddhvnw PLUS MINUS BULK
.ENDS
***************************************
.SUBCKT rpod_ell PLUS MINUS
.ENDS
***************************************
.SUBCKT rpod_ell_m PLUS MINUS B
.ENDS
***************************************
.SUBCKT rpod_m PLUS MINUS B
.ENDS
***************************************
.SUBCKT rpod_ull PLUS MINUS
.ENDS
***************************************
.SUBCKT rpod_ull_m PLUS MINUS B
.ENDS
***************************************
.SUBCKT rpodrpo_ell PLUS MINUS
.ENDS
***************************************
.SUBCKT rpodrpo_ell_m PLUS MINUS B
.ENDS
***************************************
.SUBCKT rpodrpo_m PLUS MINUS B
.ENDS
***************************************
.SUBCKT rpodrpo_ull PLUS MINUS
.ENDS
***************************************
.SUBCKT rpodrpo_ull_m PLUS MINUS B
.ENDS
***************************************
.SUBCKT rpodw_ell PLUS MINUS
.ENDS
***************************************
.SUBCKT rpodw_ell_m PLUS MINUS B
.ENDS
***************************************
.SUBCKT rpodw_m PLUS MINUS B
.ENDS
***************************************
.SUBCKT rpodw_ull PLUS MINUS
.ENDS
***************************************
.SUBCKT rpodw_ull_m PLUS MINUS B
.ENDS
***************************************
.SUBCKT rppo1_dis PLUS MINUS B
.ENDS
***************************************
.SUBCKT rppo1rpo_dis PLUS MINUS B
.ENDS
***************************************
.SUBCKT rppo1w_dis PLUS MINUS B
.ENDS
***************************************
.SUBCKT rppolyhri3k PLUS MINUS
.ENDS
***************************************
.SUBCKT rppolyhri3k_dis PLUS MINUS BULK
.ENDS
***************************************
.SUBCKT rppolyhri_dis PLUS MINUS B
.ENDS
***************************************
.SUBCKT rppolyhri_rf PLUS MINUS BULK
.ENDS
***************************************
.SUBCKT rppolyl_rf PLUS MINUS BULK
.ENDS
***************************************
.SUBCKT rppolys_rf PLUS MINUS BULK
.ENDS
***************************************
.SUBCKT rppolywo_rf PLUS MINUS BULK
.ENDS
***************************************
.SUBCKT sbd_dio_60 PLUS MINUS
.ENDS
***************************************
.SUBCKT sbd_rf PLUS MINUS BULK
.ENDS
***************************************
.SUBCKT sbd_rf_nw PLUS MINUS BULK
.ENDS
***************************************
.SUBCKT xjvar_nr36 PLUS MINUS BULK
.ENDS
***************************************
.SUBCKT xjvar_w40 PLUS MINUS BULK
.ENDS
***************************************
.SUBCKT zd_dio_4t PLUS MINUS NBL_ISO SUB
.ENDS
***************************************
.SUBCKT M1_DIFF_7
** N=79 EP=0 IP=0 FDC=0
.ENDS
***************************************
.SUBCKT M1_DIFF_10
** N=1 EP=0 IP=0 FDC=0
.ENDS
***************************************
.SUBCKT M1_DIFF_1
** N=9 EP=0 IP=0 FDC=0
.ENDS
***************************************
.SUBCKT pmos2v_7 1 2 3
** N=6 EP=3 IP=0 FDC=1
M0 3 1 2 5 P L=2e-07 W=1e-06 $X=0 $Y=0 $D=35
.ENDS
***************************************
.SUBCKT M1_DIFF_11
** N=10 EP=0 IP=0 FDC=0
.ENDS
***************************************
.SUBCKT M1_DIFF_5
** N=2 EP=0 IP=0 FDC=0
.ENDS
***************************************
.SUBCKT M1_DIFF_6
** N=9 EP=0 IP=0 FDC=0
.ENDS
***************************************
.SUBCKT M1_DIFF_9
** N=1 EP=0 IP=0 FDC=0
.ENDS
***************************************
.SUBCKT M1_DIFF_8
** N=127 EP=0 IP=0 FDC=0
.ENDS
***************************************
.SUBCKT Comparer
** N=106 EP=0 IP=168 FDC=11
M0 1 1 8 7 N L=2e-07 W=2e-06 $X=6645 $Y=-6955 $D=3
M1 10 2 3 7 N L=2e-07 W=1e-06 $X=12175 $Y=-6270 $D=3
M2 5 4 10 7 N L=2e-07 W=1e-06 $X=12915 $Y=-6270 $D=3
M3 8 1 10 7 N L=2e-07 W=3e-07 $X=18480 $Y=-7465 $D=3
M4 6 1 8 7 N L=2e-07 W=2.2e-07 $X=18480 $Y=-5385 $D=3
M5 12 6 8 7 N L=2e-07 W=1e-06 $X=24350 $Y=-6320 $D=3
M6 1 1 9 90 P L=2e-07 W=2.2e-07 $X=6645 $Y=-1040 $D=35
M7 11 3 3 92 P L=2e-07 W=1e-06 $X=12175 $Y=-1310 $D=35
M8 5 3 11 92 P L=2e-07 W=1e-06 $X=12915 $Y=-1310 $D=35
X23 5 13 6 pmos2v_7 $T=18480 -2095 0 0 $X=17570 $Y=-2525
X24 6 9 12 pmos2v_7 $T=24350 -1720 0 0 $X=23440 $Y=-2150
.ENDS
***************************************
