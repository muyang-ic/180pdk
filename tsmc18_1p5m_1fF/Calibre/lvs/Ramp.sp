* SPICE NETLIST
***************************************

.SUBCKT crtmom PLUS MINUS BULK
.ENDS
***************************************
.SUBCKT crtmom_rf PLUS MINUS BULK
.ENDS
***************************************
.SUBCKT cfmom PLUS MINUS BULK
.ENDS
***************************************
.SUBCKT cfmom_rf PLUS MINUS BULK
.ENDS
***************************************
.SUBCKT cfmom_mx PLUS1 MINUS1 PLUS2 MINUS2 BULK
.ENDS
***************************************
.SUBCKT efuse PLUS MINUS
.ENDS
***************************************
.SUBCKT hvpwdnwhvnw_dio_hvpw_3t PLUS MINUS SUB
.ENDS
***************************************
.SUBCKT lcesd1_rf PLUS MINUS
.ENDS
***************************************
.SUBCKT lcesd2_rf PLUS MINUS
.ENDS
***************************************
.SUBCKT lowcpad_rf APAD AVSS
.ENDS
***************************************
.SUBCKT lvpwdnwhvnw_dio_hvpw_3t PLUS MINUS SUB
.ENDS
***************************************
.SUBCKT mimcap_1p0_sin TOP BOT
.ENDS
***************************************
.SUBCKT mimcap_1p0_sin_3t PLUS MINUS BULK
.ENDS
***************************************
.SUBCKT mimcap_1p0_sin_hl TOP BOT
.ENDS
***************************************
.SUBCKT mimcap_1p0_sin_hl_3t PLUS MINUS BULK
.ENDS
***************************************
.SUBCKT mimcap_1p5_sin TOP BOT
.ENDS
***************************************
.SUBCKT mimcap_1p5_sin_3t PLUS MINUS BULK
.ENDS
***************************************
.SUBCKT mimcap_2p0_shield PLUS MINUS BULK
.ENDS
***************************************
.SUBCKT mimcap_2p0_sin TOP BOT
.ENDS
***************************************
.SUBCKT mimcap_2p0_sin_3t PLUS MINUS BULK
.ENDS
***************************************
.SUBCKT mimcap_2p0_wos PLUS MINUS BULK
.ENDS
***************************************
.SUBCKT mimcap_shield PLUS MINUS BULK
.ENDS
***************************************
.SUBCKT mimcap_wos PLUS MINUS BULK
.ENDS
***************************************
.SUBCKT moscap_rf33 PLUS MINUS BULK
.ENDS
***************************************
.SUBCKT moscap_rf33_nw PLUS MINUS BULK
.ENDS
***************************************
.SUBCKT moscap_rf PLUS MINUS BULK
.ENDS
***************************************
.SUBCKT moscap_rf_nw PLUS MINUS BULK
.ENDS
***************************************
.SUBCKT nch_hv5_5vnw_ac D G S B
.ENDS
***************************************
.SUBCKT LDDN D G S B
.ENDS
***************************************
.SUBCKT nch_hva_mac D G S B
.ENDS
***************************************
.SUBCKT nch_hva_ndd_mac D G S B
.ENDS
***************************************
.SUBCKT nch_hvau_ndd_mac D G S B
.ENDS
***************************************
.SUBCKT nch_hvi_mac D G BS SUB
.ENDS
***************************************
.SUBCKT nch_hviah_ndd_mac D G S B
.ENDS
***************************************
.SUBCKT nch_hvish_nbl_mac D G S B NBL_ISO SUB
.ENDS
***************************************
.SUBCKT nch_hvish_ndd_mac D G S B
.ENDS
***************************************
.SUBCKT nch_hvisl_mac D G S B
.ENDS
***************************************
.SUBCKT nch_hvnw_6t D G S B HVNW_ISO SUB
.ENDS
***************************************
.SUBCKT nch_hvs_mac D G S B
.ENDS
***************************************
.SUBCKT nch_hvs_ndd_mac D G S B
.ENDS
***************************************
.SUBCKT nch_hvsl_mac D G S B
.ENDS
***************************************
.SUBCKT nch_hvsu_ndd_mac D G S B
.ENDS
***************************************
.SUBCKT ndio_hia_rf PLUS MINUS
.ENDS
***************************************
.SUBCKT ndio_sbd_mac PLUS MINUS
.ENDS
***************************************
.SUBCKT ndld24_g5_ac D G BS SUB
.ENDS
***************************************
.SUBCKT ndld40_g5_ac D G BS SUB
.ENDS
***************************************
.SUBCKT nhvpwdnw10_4t C B E SUB
.ENDS
***************************************
.SUBCKT nhvpwdnw5_4t C B E SUB
.ENDS
***************************************
.SUBCKT nld12_g12_mac D G BS SUB
.ENDS
***************************************
.SUBCKT nld12_g2_mac D G BS SUB
.ENDS
***************************************
.SUBCKT nld14_g12_mac D G BS SUB
.ENDS
***************************************
.SUBCKT nld14_g2_mac D G BS SUB
.ENDS
***************************************
.SUBCKT nld18_g5_ac D G BS SUB
.ENDS
***************************************
.SUBCKT nld24_g5_ac D G BS SUB
.ENDS
***************************************
.SUBCKT nld32_g5_ac D G BS SUB
.ENDS
***************************************
.SUBCKT nld40_g5_ac D G BS SUB
.ENDS
***************************************
.SUBCKT nld60_g5_ac D G BS SUB
.ENDS
***************************************
.SUBCKT nmos_rf D G S B
.ENDS
***************************************
.SUBCKT nmos_rf33 D G S B
.ENDS
***************************************
.SUBCKT nmos_rf33_6t D G S B NG PG
.ENDS
***************************************
.SUBCKT nmos_rf_6t D G S B NG PG
.ENDS
***************************************
.SUBCKT nmoscap PLUS MINUS
.ENDS
***************************************
.SUBCKT nmoscap_33 PLUS MINUS
.ENDS
***************************************
.SUBCKT nmoscap_33_mis PLUS MINUS
.ENDS
***************************************
.SUBCKT nmoscap_mis PLUS MINUS
.ENDS
***************************************
.SUBCKT nvmrpodrpo_m PLUS MINUS B
.ENDS
***************************************
.SUBCKT LDDP D G S B
.ENDS
***************************************
.SUBCKT pa18_g5_ac D G S B SUB
.ENDS
***************************************
.SUBCKT pa24_g5_ac D G S B SUB
.ENDS
***************************************
.SUBCKT pa32_g5_ac D G S B SUB
.ENDS
***************************************
.SUBCKT pa40_g5_full_soa_ac D G S B SUB
.ENDS
***************************************
.SUBCKT pa40_g5_low_ron_ac D G S B SUB
.ENDS
***************************************
.SUBCKT pa50_g5_ac D G S B SUB
.ENDS
***************************************
.SUBCKT pa60_g5_full_soa_ac D G S B SUB
.ENDS
***************************************
.SUBCKT pch_5t D G S B SUB
.ENDS
***************************************
.SUBCKT pch_hva_mac D G S B SUB
.ENDS
***************************************
.SUBCKT pch_hva_pdd_mac D G S B
.ENDS
***************************************
.SUBCKT pch_hvau_pdd_mac D G S B
.ENDS
***************************************
.SUBCKT pch_hvs_mac D G S B SUB
.ENDS
***************************************
.SUBCKT pch_hvs_pdd_mac D G S B
.ENDS
***************************************
.SUBCKT pch_hvsl_mac D G S B
.ENDS
***************************************
.SUBCKT pch_hvsu_pdd_mac D G S B
.ENDS
***************************************
.SUBCKT pdio_hia_rf PLUS MINUS BULK
.ENDS
***************************************
.SUBCKT phvnw_dio_hvpw_3t PLUS MINUS SUB
.ENDS
***************************************
.SUBCKT pmos_rf D G S B
.ENDS
***************************************
.SUBCKT pmos_rf33 D G S B
.ENDS
***************************************
.SUBCKT pmos_rf33_5t D G S B PG
.ENDS
***************************************
.SUBCKT pmos_rf33_nw D G S B
.ENDS
***************************************
.SUBCKT pmos_rf33_nw_5t D G S B PG
.ENDS
***************************************
.SUBCKT pmos_rf_5t D G S B PG
.ENDS
***************************************
.SUBCKT pmos_rf_nw D G S B
.ENDS
***************************************
.SUBCKT pmos_rf_nw_5t D G S B PG
.ENDS
***************************************
.SUBCKT rhim PLUS MINUS
.ENDS
***************************************
.SUBCKT rhvnw PLUS MINUS BULK
.ENDS
***************************************
.SUBCKT rhvnw_60 PLUS MINUS BULK
.ENDS
***************************************
.SUBCKT rhvnwhvpw PLUS MINUS BULK
.ENDS
***************************************
.SUBCKT rhvpw PLUS MINUS BULK
.ENDS
***************************************
.SUBCKT rhvpw_60 PLUS MINUS BULK
.ENDS
***************************************
.SUBCKT rldpwod PLUS MINUS BULK
.ENDS
***************************************
.SUBCKT rldpwsti PLUS MINUS BULK
.ENDS
***************************************
.SUBCKT rnddhvpw PLUS MINUS BULK
.ENDS
***************************************
.SUBCKT rnod_m PLUS MINUS B
.ENDS
***************************************
.SUBCKT rnodrpo_m PLUS MINUS B
.ENDS
***************************************
.SUBCKT rnodw_m PLUS MINUS B
.ENDS
***************************************
.SUBCKT rnpo1_dis PLUS MINUS B
.ENDS
***************************************
.SUBCKT rnpo1rpo_dis PLUS MINUS B
.ENDS
***************************************
.SUBCKT rnpo1w_dis PLUS MINUS B
.ENDS
***************************************
.SUBCKT rnwod_ell PLUS MINUS
.ENDS
***************************************
.SUBCKT rnwod_ell_m PLUS MINUS B
.ENDS
***************************************
.SUBCKT rnwod_m PLUS MINUS B
.ENDS
***************************************
.SUBCKT rnwod_ull PLUS MINUS
.ENDS
***************************************
.SUBCKT rnwod_ull_m PLUS MINUS B
.ENDS
***************************************
.SUBCKT rnwsti_ell PLUS MINUS
.ENDS
***************************************
.SUBCKT rnwsti_ell_m PLUS MINUS B
.ENDS
***************************************
.SUBCKT rnwsti_m PLUS MINUS B
.ENDS
***************************************
.SUBCKT rnwsti_ull PLUS MINUS
.ENDS
***************************************
.SUBCKT rnwsti_ull_m PLUS MINUS B
.ENDS
***************************************
.SUBCKT rpbody PLUS MINUS BULK
.ENDS
***************************************
.SUBCKT rpddhvnw PLUS MINUS BULK
.ENDS
***************************************
.SUBCKT rpod_ell PLUS MINUS
.ENDS
***************************************
.SUBCKT rpod_ell_m PLUS MINUS B
.ENDS
***************************************
.SUBCKT rpod_m PLUS MINUS B
.ENDS
***************************************
.SUBCKT rpod_ull PLUS MINUS
.ENDS
***************************************
.SUBCKT rpod_ull_m PLUS MINUS B
.ENDS
***************************************
.SUBCKT rpodrpo_ell PLUS MINUS
.ENDS
***************************************
.SUBCKT rpodrpo_ell_m PLUS MINUS B
.ENDS
***************************************
.SUBCKT rpodrpo_m PLUS MINUS B
.ENDS
***************************************
.SUBCKT rpodrpo_ull PLUS MINUS
.ENDS
***************************************
.SUBCKT rpodrpo_ull_m PLUS MINUS B
.ENDS
***************************************
.SUBCKT rpodw_ell PLUS MINUS
.ENDS
***************************************
.SUBCKT rpodw_ell_m PLUS MINUS B
.ENDS
***************************************
.SUBCKT rpodw_m PLUS MINUS B
.ENDS
***************************************
.SUBCKT rpodw_ull PLUS MINUS
.ENDS
***************************************
.SUBCKT rpodw_ull_m PLUS MINUS B
.ENDS
***************************************
.SUBCKT rppo1_dis PLUS MINUS B
.ENDS
***************************************
.SUBCKT rppo1rpo_dis PLUS MINUS B
.ENDS
***************************************
.SUBCKT rppo1w_dis PLUS MINUS B
.ENDS
***************************************
.SUBCKT rppolyhri3k PLUS MINUS
.ENDS
***************************************
.SUBCKT rppolyhri3k_dis PLUS MINUS BULK
.ENDS
***************************************
.SUBCKT rppolyhri_dis PLUS MINUS B
.ENDS
***************************************
.SUBCKT rppolyhri_rf PLUS MINUS BULK
.ENDS
***************************************
.SUBCKT rppolyl_rf PLUS MINUS BULK
.ENDS
***************************************
.SUBCKT rppolys_rf PLUS MINUS BULK
.ENDS
***************************************
.SUBCKT rppolywo_rf PLUS MINUS BULK
.ENDS
***************************************
.SUBCKT sbd_dio_60 PLUS MINUS
.ENDS
***************************************
.SUBCKT sbd_rf PLUS MINUS BULK
.ENDS
***************************************
.SUBCKT sbd_rf_nw PLUS MINUS BULK
.ENDS
***************************************
.SUBCKT xjvar_nr36 PLUS MINUS BULK
.ENDS
***************************************
.SUBCKT xjvar_w40 PLUS MINUS BULK
.ENDS
***************************************
.SUBCKT zd_dio_4t PLUS MINUS NBL_ISO SUB
.ENDS
***************************************
.SUBCKT M1_DIFF_16
** N=169 EP=0 IP=0 FDC=0
.ENDS
***************************************
.SUBCKT M1_DIFF_12
** N=1 EP=0 IP=0 FDC=0
.ENDS
***************************************
.SUBCKT rnwell_5 1 2
** N=3 EP=2 IP=0 FDC=1
R0 1 2 3652.82 $[WR] $X=850 $Y=0 $D=145
.ENDS
***************************************
.SUBCKT M1_DIFF_6
** N=2 EP=0 IP=0 FDC=0
.ENDS
***************************************
.SUBCKT M1_DIFF_8
** N=2 EP=0 IP=0 FDC=0
.ENDS
***************************************
.SUBCKT rnwell_9 1 2
** N=3 EP=2 IP=0 FDC=1
R0 1 2 5250.79 $[WR] $X=850 $Y=0 $D=145
.ENDS
***************************************
.SUBCKT rnwell_8 1 2
** N=3 EP=2 IP=0 FDC=1
R0 1 2 5937.21 $[WR] $X=850 $Y=0 $D=145
.ENDS
***************************************
.SUBCKT M1_DIFF_7
** N=2 EP=0 IP=0 FDC=0
.ENDS
***************************************
.SUBCKT rnwell_6 1 2
** N=3 EP=2 IP=0 FDC=1
R0 1 2 4566.58 $[WR] $X=850 $Y=0 $D=145
.ENDS
***************************************
.SUBCKT M1_DIFF_0
** N=2 EP=0 IP=0 FDC=0
.ENDS
***************************************
.SUBCKT M1_DIFF_1
** N=2 EP=0 IP=0 FDC=0
.ENDS
***************************************
.SUBCKT rnwell_4 1 2
** N=3 EP=2 IP=0 FDC=1
R0 1 2 2739.06 $[WR] $X=850 $Y=0 $D=145
.ENDS
***************************************
.SUBCKT M1_DIFF_17
** N=1 EP=0 IP=0 FDC=0
.ENDS
***************************************
.SUBCKT M1_DIFF_18
** N=227 EP=0 IP=0 FDC=0
.ENDS
***************************************
.SUBCKT Ramp
** N=42 EP=0 IP=128 FDC=51
M0 1 2 7 6 N L=2e-07 W=1e-06 $X=-11270 $Y=-5170 $D=3
M1 11 1 8 6 N L=6e-07 W=1e-06 $X=-10600 $Y=-775 $D=3
M2 7 2 1 6 N L=2e-07 W=1e-06 $X=-10530 $Y=-5170 $D=3
M3 1 2 7 6 N L=2e-07 W=1e-06 $X=-9790 $Y=-5170 $D=3
M4 8 1 11 6 N L=6e-07 W=1e-06 $X=-9460 $Y=-775 $D=3
M5 7 2 1 6 N L=2e-07 W=1e-06 $X=-9050 $Y=-5170 $D=3
M6 3 1 8 6 N L=6e-07 W=1e-06 $X=-8320 $Y=-775 $D=3
M7 1 2 7 6 N L=2e-07 W=1e-06 $X=-8310 $Y=-5170 $D=3
M8 7 2 1 6 N L=2e-07 W=1e-06 $X=-7570 $Y=-5170 $D=3
M9 1 2 7 6 N L=2e-07 W=1e-06 $X=-6830 $Y=-5170 $D=3
M10 4 3 4 6 N L=2e-07 W=1.5e-06 $X=-40 $Y=-1140 $D=3
M11 12 4 9 6 N L=2e-07 W=1e-06 $X=5860 $Y=-970 $D=3
M12 9 4 12 6 N L=2e-07 W=1e-06 $X=6600 $Y=-970 $D=3
M13 12 4 9 6 N L=2e-07 W=1e-06 $X=7340 $Y=-970 $D=3
M14 9 4 12 6 N L=2e-07 W=1e-06 $X=8080 $Y=-970 $D=3
M15 4 5 10 6 N L=2e-07 W=1e-06 $X=16375 $Y=-695 $D=3
M16 10 5 4 6 N L=2e-07 W=1e-06 $X=17115 $Y=-695 $D=3
M17 4 5 10 6 N L=2e-07 W=1e-06 $X=17855 $Y=-695 $D=3
M18 10 5 4 6 N L=2e-07 W=1e-06 $X=18595 $Y=-695 $D=3
M19 4 5 10 6 N L=2e-07 W=1e-06 $X=19335 $Y=-695 $D=3
M20 10 5 4 6 N L=2e-07 W=1e-06 $X=20075 $Y=-695 $D=3
M21 4 5 10 6 N L=2e-07 W=1e-06 $X=20815 $Y=-695 $D=3
M22 10 5 4 6 N L=2e-07 W=1e-06 $X=21555 $Y=-695 $D=3
M23 4 5 10 6 N L=2e-07 W=1e-06 $X=22295 $Y=-695 $D=3
M24 10 5 4 6 N L=2e-07 W=1e-06 $X=23035 $Y=-695 $D=3
X29 17 9 rnwell_5 $T=-860 -17400 0 0 $X=-860 $Y=-17400
X30 17 19 rnwell_5 $T=-860 -13700 0 0 $X=-860 $Y=-13700
X31 18 19 rnwell_5 $T=-860 -10000 0 0 $X=-860 $Y=-10000
X32 18 4 rnwell_5 $T=-860 -6300 0 0 $X=-860 $Y=-6300
X33 29 28 rnwell_5 $T=34005 -17400 0 90 $X=31905 $Y=-17400
X34 28 10 rnwell_5 $T=34005 -5800 0 90 $X=31905 $Y=-5800
X35 30 31 rnwell_5 $T=34005 5800 0 90 $X=31905 $Y=5800
X47 12 25 rnwell_9 $T=12595 2575 0 0 $X=12595 $Y=2575
X48 24 25 rnwell_9 $T=12595 6275 0 0 $X=12595 $Y=6275
X49 24 26 rnwell_9 $T=12595 9975 0 0 $X=12595 $Y=9975
X50 32 26 rnwell_9 $T=12595 13675 0 0 $X=12595 $Y=13675
X51 23 27 rnwell_8 $T=12275 -13700 0 0 $X=12275 $Y=-13700
X52 22 4 rnwell_8 $T=12275 -6300 0 0 $X=12275 $Y=-6300
X53 23 10 rnwell_8 $T=12280 -17400 0 0 $X=12280 $Y=-17400
X54 22 27 rnwell_8 $T=12280 -10000 0 0 $X=12280 $Y=-10000
X57 1 20 rnwell_6 $T=-2075 2575 0 0 $X=-2075 $Y=2575
X58 16 20 rnwell_6 $T=-2075 6275 0 0 $X=-2075 $Y=6275
X59 16 21 rnwell_6 $T=-2075 9975 0 0 $X=-2075 $Y=9975
X60 4 21 rnwell_6 $T=-2075 13675 0 0 $X=-2075 $Y=13675
X65 7 15 rnwell_4 $T=-12930 -17400 0 0 $X=-12930 $Y=-17400
X66 13 15 rnwell_4 $T=-12930 -13700 0 0 $X=-12930 $Y=-13700
X67 13 2 rnwell_4 $T=-12930 -10000 0 0 $X=-12930 $Y=-10000
X68 14 3 rnwell_4 $T=-12930 2575 0 0 $X=-12930 $Y=2575
X69 14 4 rnwell_4 $T=-12930 6275 0 0 $X=-12930 $Y=6275
X70 33 34 rnwell_4 $T=-12930 9975 0 0 $X=-12930 $Y=9975
X71 35 36 rnwell_4 $T=-12930 13675 0 0 $X=-12930 $Y=13675
.ENDS
***************************************
