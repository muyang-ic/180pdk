library dio_dnw_cor

section ff_dio_dnw
include "cmn018_assp_v1d2.scs" section = ff_dio_dnw
endsection ff_dio_dnw

section ss_dio_dnw
include "cmn018_assp_v1d2.scs" section = ss_dio_dnw
endsection ss_dio_dnw

section tt_dio_dnw
include "cmn018_assp_v1d2.scs" section = tt_dio_dnw
endsection tt_dio_dnw

endlibrary dio_dnw_cor
