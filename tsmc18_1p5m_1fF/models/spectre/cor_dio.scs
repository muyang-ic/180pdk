library dio_cor

section ff_dio
include "cmn018_assp_v1d2.scs" section = ff_dio
endsection ff_dio

section ss_dio
include "cmn018_assp_v1d2.scs" section = ss_dio
endsection ss_dio

section tt_dio
include "cmn018_assp_v1d2.scs" section = tt_dio
endsection tt_dio

endlibrary dio_cor
