library res_cor

section ff_res
include "cmn018_assp_v1d2.scs" section = ff_res
endsection ff_res

section ss_res
include "cmn018_assp_v1d2.scs" section = ss_res
endsection ss_res

section tt_res
include "cmn018_assp_v1d2.scs" section = tt_res
endsection tt_res

endlibrary res_cor
