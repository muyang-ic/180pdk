//  **************************************************************
//  *  TSMC SPICE MODEL --- Security B - TSMC Restricted Secret  *
//  **************************************************************
section tt_lib
include "cmn018_assp_v1d3.scs" section=tt
include "cmn018_assp_v1d3.scs" section=tt_3v
include "cmn018_assp_v1d3.scs" section=tt_m
include "cmn018_assp_v1d3.scs" section=tt_3m
include "cmn018_assp_v1d3.scs" section=tt_na
include "cmn018_assp_v1d3.scs" section=tt_3vna
include "cmn018_assp_v1d3.scs" section=tt_ana33
include "cmn018_assp_v1d3.scs" section=tt_bip
include "cmn018_assp_v1d3.scs" section=tt_bip3
include "cmn018_assp_v1d3.scs" section=tt_dio3
include "cmn018_assp_v1d3.scs" section=tt_dio_m
include "cmn018_assp_v1d3.scs" section=tt_dio_3m
include "cmn018_assp_v1d3.scs" section=tt_dio_dnw
include "cmn018_assp_v1d3.scs" section=tt_res
include "cmn018_assp_v1d3.scs" section=tt_dio
include "cmn018_assp_v1d3.scs" section=tt_disres
include "cmn018_assp_v1d3.scs" section=tt_bbmvar
include "cmn018_assp_v1d3.scs" section=tt_mim
include "cmn018_assp_v1d3.scs" section=tt_rtmom
include "cmn018_assp_v1d3.scs" section=tt_fmom
parOpt options redefinedparams=ignore
parameters  mismatchflag_mos=0
parameters  mismatchflag_mos_3v=0
parameters  mismatchflag_mos_m=0
parameters  mismatchflag_mos_3m=0
parameters  mismatchflag_mos_na=0
parameters  mismatchflag_mos_3vna=0
parameters  mismatchflag_mos_ana33=0
parameters  mismatchflag_bip=0
parameters  mismatchflag_res=0
parameters  mismatchflag_disres=0
parameters  mismatchflag_mim=0
parameters  mismatchflag_rtmom=0
parameters  mismatchflag_fmom=0
endsection tt_lib

section ss_lib
include "cmn018_assp_v1d3.scs" section=ss
include "cmn018_assp_v1d3.scs" section=ss_3v
include "cmn018_assp_v1d3.scs" section=ss_m
include "cmn018_assp_v1d3.scs" section=ss_3m
include "cmn018_assp_v1d3.scs" section=ss_na
include "cmn018_assp_v1d3.scs" section=ss_3vna
include "cmn018_assp_v1d3.scs" section=ss_ana33
include "cmn018_assp_v1d3.scs" section=ss_bip
include "cmn018_assp_v1d3.scs" section=ss_bip3
include "cmn018_assp_v1d3.scs" section=ss_dio3
include "cmn018_assp_v1d3.scs" section=ss_dio_m
include "cmn018_assp_v1d3.scs" section=ss_dio_3m
include "cmn018_assp_v1d3.scs" section=ss_dio_dnw
include "cmn018_assp_v1d3.scs" section=ss_res
include "cmn018_assp_v1d3.scs" section=ss_dio
include "cmn018_assp_v1d3.scs" section=ss_disres
include "cmn018_assp_v1d3.scs" section=ss_bbmvar
include "cmn018_assp_v1d3.scs" section=ss_mim
include "cmn018_assp_v1d3.scs" section=ss_rtmom
include "cmn018_assp_v1d3.scs" section=ss_fmom
parOpt options redefinedparams=ignore
parameters  mismatchflag_mos=0
parameters  mismatchflag_mos_3v=0
parameters  mismatchflag_mos_m=0
parameters  mismatchflag_mos_3m=0
parameters  mismatchflag_mos_na=0
parameters  mismatchflag_mos_3vna=0
parameters  mismatchflag_mos_ana33=0
parameters  mismatchflag_bip=0
parameters  mismatchflag_res=0
parameters  mismatchflag_disres=0
parameters  mismatchflag_mim=0
parameters  mismatchflag_rtmom=0
parameters  mismatchflag_fmom=0
endsection ss_lib

section ff_lib
include "cmn018_assp_v1d3.scs" section=ff
include "cmn018_assp_v1d3.scs" section=ff_3v
include "cmn018_assp_v1d3.scs" section=ff_m
include "cmn018_assp_v1d3.scs" section=ff_3m
include "cmn018_assp_v1d3.scs" section=ff_na
include "cmn018_assp_v1d3.scs" section=ff_3vna
include "cmn018_assp_v1d3.scs" section=ff_ana33
include "cmn018_assp_v1d3.scs" section=ff_bip
include "cmn018_assp_v1d3.scs" section=ff_bip3
include "cmn018_assp_v1d3.scs" section=ff_dio3
include "cmn018_assp_v1d3.scs" section=ff_dio_m
include "cmn018_assp_v1d3.scs" section=ff_dio_3m
include "cmn018_assp_v1d3.scs" section=ff_dio_dnw
include "cmn018_assp_v1d3.scs" section=ff_res
include "cmn018_assp_v1d3.scs" section=ff_dio
include "cmn018_assp_v1d3.scs" section=ff_disres
include "cmn018_assp_v1d3.scs" section=ff_bbmvar
include "cmn018_assp_v1d3.scs" section=ff_mim
include "cmn018_assp_v1d3.scs" section=ff_rtmom
include "cmn018_assp_v1d3.scs" section=ff_fmom
parOpt options redefinedparams=ignore
parameters  mismatchflag_mos=0
parameters  mismatchflag_mos_3v=0
parameters  mismatchflag_mos_m=0
parameters  mismatchflag_mos_3m=0
parameters  mismatchflag_mos_na=0
parameters  mismatchflag_mos_3vna=0
parameters  mismatchflag_mos_ana33=0
parameters  mismatchflag_bip=0
parameters  mismatchflag_res=0
parameters  mismatchflag_disres=0
parameters  mismatchflag_mim=0
parameters  mismatchflag_rtmom=0
parameters  mismatchflag_fmom=0
endsection ff_lib

section sf_lib
include "cmn018_assp_v1d3.scs" section=sf
include "cmn018_assp_v1d3.scs" section=sf_3v
include "cmn018_assp_v1d3.scs" section=sf_m
include "cmn018_assp_v1d3.scs" section=sf_3m
include "cmn018_assp_v1d3.scs" section=sf_na
include "cmn018_assp_v1d3.scs" section=sf_3vna
include "cmn018_assp_v1d3.scs" section=sf_ana33
include "cmn018_assp_v1d3.scs" section=tt_bip
include "cmn018_assp_v1d3.scs" section=tt_bip3
include "cmn018_assp_v1d3.scs" section=tt_dio3
include "cmn018_assp_v1d3.scs" section=tt_dio_m
include "cmn018_assp_v1d3.scs" section=tt_dio_3m
include "cmn018_assp_v1d3.scs" section=tt_dio_dnw
include "cmn018_assp_v1d3.scs" section=tt_res
include "cmn018_assp_v1d3.scs" section=tt_dio
include "cmn018_assp_v1d3.scs" section=tt_disres
include "cmn018_assp_v1d3.scs" section=tt_bbmvar
include "cmn018_assp_v1d3.scs" section=tt_mim
include "cmn018_assp_v1d3.scs" section=tt_rtmom
include "cmn018_assp_v1d3.scs" section=tt_fmom
parOpt options redefinedparams=ignore
parameters  mismatchflag_mos=0
parameters  mismatchflag_mos_3v=0
parameters  mismatchflag_mos_m=0
parameters  mismatchflag_mos_3m=0
parameters  mismatchflag_mos_na=0
parameters  mismatchflag_mos_3vna=0
parameters  mismatchflag_mos_ana33=0
parameters  mismatchflag_bip=0
parameters  mismatchflag_res=0
parameters  mismatchflag_disres=0
parameters  mismatchflag_mim=0
parameters  mismatchflag_rtmom=0
parameters  mismatchflag_fmom=0
endsection sf_lib

section fs_lib
include "cmn018_assp_v1d3.scs" section=fs
include "cmn018_assp_v1d3.scs" section=fs_3v
include "cmn018_assp_v1d3.scs" section=fs_m
include "cmn018_assp_v1d3.scs" section=fs_3m
include "cmn018_assp_v1d3.scs" section=fs_na
include "cmn018_assp_v1d3.scs" section=fs_3vna
include "cmn018_assp_v1d3.scs" section=fs_ana33
include "cmn018_assp_v1d3.scs" section=tt_bip
include "cmn018_assp_v1d3.scs" section=tt_bip3
include "cmn018_assp_v1d3.scs" section=tt_dio3
include "cmn018_assp_v1d3.scs" section=tt_dio_m
include "cmn018_assp_v1d3.scs" section=tt_dio_3m
include "cmn018_assp_v1d3.scs" section=tt_dio_dnw
include "cmn018_assp_v1d3.scs" section=tt_res
include "cmn018_assp_v1d3.scs" section=tt_dio
include "cmn018_assp_v1d3.scs" section=tt_disres
include "cmn018_assp_v1d3.scs" section=tt_bbmvar
include "cmn018_assp_v1d3.scs" section=tt_mim
include "cmn018_assp_v1d3.scs" section=tt_rtmom
include "cmn018_assp_v1d3.scs" section=tt_fmom
parOpt options redefinedparams=ignore
parameters  mismatchflag_mos=0
parameters  mismatchflag_mos_3v=0
parameters  mismatchflag_mos_m=0
parameters  mismatchflag_mos_3m=0
parameters  mismatchflag_mos_na=0
parameters  mismatchflag_mos_3vna=0
parameters  mismatchflag_mos_ana33=0
parameters  mismatchflag_bip=0
parameters  mismatchflag_res=0
parameters  mismatchflag_disres=0
parameters  mismatchflag_mim=0
parameters  mismatchflag_rtmom=0
parameters  mismatchflag_fmom=0
endsection fs_lib

section mc_lib
include "cmn018_assp_v1d3.scs" section=mc
include "cmn018_assp_v1d3.scs" section=mc_3v
include "cmn018_assp_v1d3.scs" section=mc_m
include "cmn018_assp_v1d3.scs" section=mc_3m
include "cmn018_assp_v1d3.scs" section=mc_na
include "cmn018_assp_v1d3.scs" section=mc_3vna
include "cmn018_assp_v1d3.scs" section=mc_ana33
include "cmn018_assp_v1d3.scs" section=mc_bip
include "cmn018_assp_v1d3.scs" section=tt_bip3
include "cmn018_assp_v1d3.scs" section=tt_dio3
include "cmn018_assp_v1d3.scs" section=tt_dio_m
include "cmn018_assp_v1d3.scs" section=tt_dio_3m
include "cmn018_assp_v1d3.scs" section=tt_dio_dnw
include "cmn018_assp_v1d3.scs" section=mc_res
include "cmn018_assp_v1d3.scs" section=tt_dio
include "cmn018_assp_v1d3.scs" section=mc_disres
include "cmn018_assp_v1d3.scs" section=mc_bbmvar
include "cmn018_assp_v1d3.scs" section=mc_mim
include "cmn018_assp_v1d3.scs" section=mc_rtmom
include "cmn018_assp_v1d3.scs" section=mc_fmom
include "cmn018_assp_v1d3.scs" section=stat
include "cmn018_assp_v1d3.scs" section=stat_res
include "cmn018_assp_v1d3.scs" section=stat_mim
include "cmn018_assp_v1d3.scs" section=stat_mom
parOpt options redefinedparams=ignore
parameters  mismatchflag_mos=0
parameters  mismatchflag_mos_3v=0
parameters  mismatchflag_mos_m=0
parameters  mismatchflag_mos_3m=0
parameters  mismatchflag_mos_na=0
parameters  mismatchflag_mos_3vna=0
parameters  mismatchflag_mos_ana33=0
parameters  mismatchflag_bip=0
parameters  mismatchflag_res=0
parameters  mismatchflag_disres=0
parameters  mismatchflag_mim=0
parameters  mismatchflag_rtmom=0
parameters  mismatchflag_fmom=0
endsection mc_lib

section mismatch_lib
include "cmn018_assp_v1d3.scs" section=tt
include "cmn018_assp_v1d3.scs" section=tt_3v
include "cmn018_assp_v1d3.scs" section=tt_m
include "cmn018_assp_v1d3.scs" section=tt_3m
include "cmn018_assp_v1d3.scs" section=tt_na
include "cmn018_assp_v1d3.scs" section=tt_3vna
include "cmn018_assp_v1d3.scs" section=tt_ana33
include "cmn018_assp_v1d3.scs" section=tt_bip
include "cmn018_assp_v1d3.scs" section=tt_bip3
include "cmn018_assp_v1d3.scs" section=tt_dio3
include "cmn018_assp_v1d3.scs" section=tt_dio_m
include "cmn018_assp_v1d3.scs" section=tt_dio_3m
include "cmn018_assp_v1d3.scs" section=tt_dio_dnw
include "cmn018_assp_v1d3.scs" section=tt_res
include "cmn018_assp_v1d3.scs" section=tt_dio
include "cmn018_assp_v1d3.scs" section=tt_disres
include "cmn018_assp_v1d3.scs" section=tt_bbmvar
include "cmn018_assp_v1d3.scs" section=tt_mim
include "cmn018_assp_v1d3.scs" section=tt_rtmom
include "cmn018_assp_v1d3.scs" section=tt_fmom
include "cmn018_assp_v1d3.scs" section=stat_mis
include "cmn018_assp_v1d3.scs" section=stat_mis_3v
include "cmn018_assp_v1d3.scs" section=stat_mis_m
include "cmn018_assp_v1d3.scs" section=stat_mis_3m
include "cmn018_assp_v1d3.scs" section=stat_mis_na
include "cmn018_assp_v1d3.scs" section=stat_mis_3vna
include "cmn018_assp_v1d3.scs" section=stat_mis_ana33
include "cmn018_assp_v1d3.scs" section=stat_mis_bip
include "cmn018_assp_v1d3.scs" section=stat_mis_res
include "cmn018_assp_v1d3.scs" section=stat_mis_disres
include "cmn018_assp_v1d3.scs" section=stat_mis_mim
include "cmn018_assp_v1d3.scs" section=stat_mis_rtmom
include "cmn018_assp_v1d3.scs" section=stat_mis_fmom
parOpt options redefinedparams=ignore
parameters  mismatchflag_mos=1
parameters  mismatchflag_mos_3v=1
parameters  mismatchflag_mos_m=1
parameters  mismatchflag_mos_3m=1
parameters  mismatchflag_mos_na=1
parameters  mismatchflag_mos_3vna=1
parameters  mismatchflag_mos_ana33=1
parameters  mismatchflag_bip=1
parameters  mismatchflag_res=1
parameters  mismatchflag_disres=1
parameters  mismatchflag_mim=1
parameters  mismatchflag_rtmom=1
parameters  mismatchflag_fmom=1
endsection mismatch_lib
