library rtmom_cor

section ff_rtmom
include "cmn018_assp_v1d2.scs" section = ff_rtmom
endsection ff_rtmom

section ss_rtmom
include "cmn018_assp_v1d2.scs" section = ss_rtmom
endsection ss_rtmom

section tt_rtmom
include "cmn018_assp_v1d2.scs" section = tt_rtmom
endsection tt_rtmom

endlibrary rtmom_cor
