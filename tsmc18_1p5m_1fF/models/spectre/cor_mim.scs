library mim_cor

section ff_mim
include "cmn018_assp_v1d2.scs" section = ff_mim
endsection ff_mim

section ss_mim
include "cmn018_assp_v1d2.scs" section = ss_mim
endsection ss_mim

section tt_mim
include "cmn018_assp_v1d2.scs" section = tt_mim
endsection tt_mim

endlibrary mim_cor
