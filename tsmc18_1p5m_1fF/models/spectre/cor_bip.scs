library bip_cor

section ff_bip
include "cmn018_assp_v1d2.scs" section = ff_bip
endsection ff_bip

section ss_bip
include "cmn018_assp_v1d2.scs" section = ss_bip
endsection ss_bip

section tt_bip
include "cmn018_assp_v1d2.scs" section = tt_bip
endsection tt_bip

endlibrary bip_cor
